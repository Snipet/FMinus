* clipper.cir: Yeh's RC diode clipper (DAFx-07): R1 into C1, an antiparallel 1N914 pair across it; the circuit of
* fminus.md's Tables 1 to 3 (example-circuits --tables runs it with their 45.0 mV). No configuration directives:
* Phase 0's defaults (8x, plain omega3 + 2 Newton steps; docs/circuits.md)
.title Clipper
.input  u    in   scale=1
.output vout a
.target solver=-60dB alias=-60dB level=4.5V freq=3k
R1     in a  2.2k
C1     a  0  10n
D1     a  0  1N914
D2     0  a  1N914
.model 1N914 D(IS=2.52n N=1.752)
.end
