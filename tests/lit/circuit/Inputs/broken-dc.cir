* broken-dc.cir: errors.test's DC operating point errors of the topology: a loop of a V source and an inductor (their
* DC current is undefined), and a node a current source and a capacitor alone reach (its DC voltage is); .input's node
* and an op amp's output are sources to ground, so an inductor from .input's node to a V source's, or from an op amp's
* output to ground, is such a loop too
.title Broken
.input  u    in
.output vout a
R1     in  a   10k
R2     a   0   1k
V1     b   0   1
L1     b   0   1m
R3     b   a   1k
I1     0   x   1m
C1     x   0   1n
V2     vb  0   4.5
L2     in  vb  1m
R4     a   c   1k
X1     c   o   o   opamp
L3     o   0   1m
.end
