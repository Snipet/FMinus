* ts2-gen.cir: screamer-clip.cir as experiments/ts2.fm computes it: N Vt 45.3 mV, no ADAA, omega3 + 1 step at 4x
.title ScreamerClipGen
.input  u    p1   scale=1
.output vout v2
.pot    drive 0.5 audio
.oversample 4 iir blocks=auto
.adaa off
.solver omega(1)
XU1    p1  n1  v2  opamp
R4     n1  z1  4.7k
C3     z1  0   47n
R6     n1  f1  51k
Pdrive f1  v2  500k {drive} taper=audio
C4     n1  v2  51p
D1     n1  v2  1N914
D2     v2  n1  1N914
.model 1N914 D(IS=2.52n N=1.75140653)
.end
